** analog simulation of extracted spice netlist

** PDK path appropriate for iic-osic-tools docker image, change it if you have a different setup
.include $PDK_ROOT/gf180mcuD/libs.tech/ngspice/design.ngspice
.lib $PDK_ROOT/gf180mcuD/libs.tech/ngspice/sm141064.ngspice typical

** spice extracted from hardened project using magic's extract/ext2spice
.include tt_um_microlane_demo.spice

** instantiate the device under test
Xdut VPWR VGND ena clk rst_n
+ ui_in[0] ui_in[1] ui_in[2] ui_in[3] ui_in[4] ui_in[5] ui_in[6] ui_in[7]
+ uio_in[0] uio_in[1] uio_in[2] uio_in[3] uio_in[4] uio_in[5] uio_in[6] uio_in[7]
+ uo_out[0] uo_out[1] uo_out[2] uo_out[3] uo_out[4] uo_out[5] uo_out[6] uo_out[7]
+ uio_out[0] uio_out[1] uio_out[2] uio_out[3] uio_out[4] uio_out[5] uio_out[6] uio_out[7]
+ uio_oe[0] uio_oe[1] uio_oe[2] uio_oe[3] uio_oe[4] uio_oe[5] uio_oe[6] uio_oe[7]
+ tt_um_microlane_demo

** generate input signals
VVPWR      VPWR      GND  5.0
VVGND      VGND      GND  0
Vena       ena       GND  5.0
Vclk       clk       GND  PULSE(0 5.0 1u 0 0 1u 2u 0)
Vrst_n     rst_n     GND  PULSE(5.0 0 2.4u 0 0 10u 12.4u 1)
Vui_in[0]  ui_in[0]  GND  0
Vui_in[1]  ui_in[1]  GND  0
Vui_in[2]  ui_in[2]  GND  0
Vui_in[3]  ui_in[3]  GND  0
Vui_in[4]  ui_in[4]  GND  0
Vui_in[5]  ui_in[5]  GND  0
Vui_in[6]  ui_in[6]  GND  0
Vui_in[7]  ui_in[7]  GND  0
Vuio_in[0] uio_in[0] GND  0
Vuio_in[1] uio_in[1] GND  0
Vuio_in[2] uio_in[2] GND  0
Vuio_in[3] uio_in[3] GND  0
Vuio_in[4] uio_in[4] GND  0
Vuio_in[5] uio_in[5] GND  0
Vuio_in[6] uio_in[6] GND  0
Vuio_in[7] uio_in[7] GND  0

** simulation setup
.control
  save clk rst_n uo_out[0] uo_out[1] uo_out[2] uo_out[3] uo_out[4] uo_out[5] uo_out[6] uo_out[7]
  tran 10n 202u uic
  write sim.raw
  remzerovec
.endc

.end
